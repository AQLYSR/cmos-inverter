.SUBCKT INVERTER VDD VSS IN OUT
M1 OUT IN VSS VSS sky130_fd_pr__nfet_01v8 w=1.0 l=0.15
M2 OUT IN VDD VDD sky130_fd_pr__pfet_01v8 w=1.0 l=0.15
.ENDS INVERTER
