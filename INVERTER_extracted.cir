.SUBCKT INVERTER VDD VSS IN OUT
XM1 OUT IN VSS VSS sky130_fd_pr__nfet_01v8 L=0.15 W=1.0
XM2 OUT IN VDD VDD sky130_fd_pr__pfet_01v8 L=0.15 W=1.0
.ENDS INVERTER
